//=============================================================================
//  Copyright (c) 2017 Intel Corporation, all rights reserved.
//  THIS PROGRAM IS AN UNPUBLISHED WORK FULLY PROTECTED BY
//  COPYRIGHT LAWS AND IS CONSIDERED A TRADE SECRET BELONGING
//  TO THE INTEL CORPORATION.
//
//  Intel Confidential
//=============================================================================
//  Unit Name                                           : 
//  Primary Unit Owner                                  : 
//  Secondary Contact                                   : 
//=============================================================================
//
// The following is the Fuse List captured in SystemRDL
//
//=============================================================================

`include "fuse_udp.rdl"

  //------------------------------------------------------------------------------
  // mss_top Fuse Address Map
  //------------------------------------------------------------------------------
  addrmap mss_top_Fuse_Map {
  //--------------------------------------------------------------------------
  // This is a default field type that contains all of the required UDPs and
  // SystemRDL properties that must be defined per field.  Each field within
  // a register instantiates this default field to the correct size and
  // overrides the default values for the UDPs.
  //--------------------------------------------------------------------------

  field default_field {
    //**** DO NOT MODIFY CODE BELOW ****
    <% foreach $prop (keys %FieldProps) { %>
      <%=$prop%> = <%=$FieldProps{$prop}%>;
    <% } %>
    //**** DO NOT MODIFY CODE ABOVE ****

    // Description of this register field.
    desc = "This is the default field any register that instantiates this field will inherit all of the properties that are assigned in this field.";
  };

    TableType = "Fuse IP Template 2.1.12";

    PrivatePort = false;
    CmplFmt = 1;
    LegacyConverted = false;
    FuseMemLimit = "";
    FuseMemLimitIntelHVM = "";
    FuseMemLimitIntelIFP = "";
    FuseMemLimitOEMIFP = "";
    StrapMemLimit = "";
    PullTrigger = "Waived";

    reg mss_top_fuse {
        regwidth = 32;  // make blueprint happy 
        
        default_field mss_top_dummy = 1'h0;
        mss_top_dummy->name = "mss_top_dummy";
        mss_top_dummy->FUSE_WIDTH = 1;
        mss_top_dummy->RcvrAddr = 16'h0040;
        mss_top_dummy->StartBit = 1;
        mss_top_dummy->FuseDefaultValue = 1'h1;
        mss_top_dummy->Category = "IntelHVM";
        mss_top_dummy->LLDD = false;
        mss_top_dummy->Shared = true;
        mss_top_dummy->SharedTag = "";
        mss_top_dummy->PullOnce = false;
        mss_top_dummy->BlkOnDbg = false;
        mss_top_dummy->JTagRD = true;
        mss_top_dummy->JTagWR = true;
        mss_top_dummy->CSRRD = true;
        mss_top_dummy->CSRWR = true;
        mss_top_dummy->RD4Err = true;
        mss_top_dummy->LockoutValidIDTag = "";
        mss_top_dummy->desc = "WL pulse width";

        mss_top_dummy->Group = "DirectFuse";\nmss_top_dummy->ArrayType = "HighDensity";\nmss_top_dummy->Class = "Waived";\nmss_top_dummy->Consumer = "Waived";\nmss_top_dummy->EncodingValues = "two phases,1'h0; three phase,1'h1";\nmss_top_dummy->EncodingValueType = "KeyValuePairs";\nmss_top_dummy->IPOwner = "oshitrit";\nmss_top_dummy->RTLSignalPath = "sapmas.fuse_manager.fuse_array.FuseArraySBnnnH[0][1:1]";\nmss_top_dummy->SubClass = "Waived";\nmss_top_dummy->VFOverrideDisable = false;\nmss_top_dummy->IPResetType = "Waived";\nmss_top_dummy->ExternalCustomerVisible = false;\nmss_top_dummy->Units = "";\nmss_top_dummy->GroupNumber = 8'h00;\n

    };
    
    mss_top_fuse mss_top_fuse;
};
